addrmap gpio {
    name = "Generic MMIO GPIO";
    desc = "Basic memory-mapped GPIO controller matching the Linux
    basic-mmio-gpio driver (drivers/gpio/gpio-mmio.c). A data register
    drives/samples the pins and a direction register selects in/out.";

    default sw = rw;
    default hw = r;

    reg {
        name = "DATA";
        desc = "GPIO data register.
        Read: returns the current level of each pin.
        Write: drives the value onto pins configured as outputs.";

        field {
            name = "DATA";
            desc = "One bit per GPIO line.";

            sw = rw;
            hw = rw;
        } data[31:0] = 0x0;
    } data @ 0x0;

    reg {
        name = "DIRECTION";
        desc = "GPIO direction register.
        0 = pin is an input, 1 = pin is an output.";

        field {
            name = "DIRECTION";
            desc = "One bit per GPIO line: 0 = input, 1 = output.";

            sw = rw;
            hw = r;
        } direction[31:0] = 0x0;
    } direction @ 0x4;
};
