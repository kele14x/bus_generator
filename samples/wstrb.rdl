addrmap wstrb {
    name = "WSTRB Test";

    default sw = rw;
    default hw = r;
    default memwidth = 32;

    reg {
        name = "Mixed Register";

        field {
            name = "LOW";
            sw = rw;
            hw = r;
        } low[3:0] = 0x0;

        field {
            name = "MIXED";
            sw = rw;
            hw = rw;
        } mixed[11:4] = 0x0;

        field {
            name = "HIGH";
            sw = rw;
            hw = r;
        } high[23:12] = 0x0;
    } regs @ 0x0;

    external mem {
        mementries = 2;
        sw = rw;
    } ram @ 0x100;
};
