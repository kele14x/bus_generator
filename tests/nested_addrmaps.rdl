addrmap child_map {
    default sw = rw;
    default hw = r;

    reg {
        field {
            sw = rw;
            hw = r;
        } value[31:0] = 0x0;
    } status @ 0x0;
};

addrmap nested_addrmaps {
    child_map left @ 0x0;
    child_map right @ 0x100;
};
